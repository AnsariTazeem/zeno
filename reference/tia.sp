.subckt feedback sense out vref
Rf out sense 10000
Cf out sense 8.2e-12
Rg sense vref 5000
.ends feedback
