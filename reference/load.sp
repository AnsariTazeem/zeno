.subckt feedback drive load fb
Riso drive load 1000
Rfb drive fb 1000
Rg fb 0 100000
.ends feedback
