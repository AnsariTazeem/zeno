.subckt feedback sense out vref
Rf sense out 10000
Cf sense out 8.2e-12
Rga sense return_mid 2500
Rgb return_mid vref 2500
.ends feedback
