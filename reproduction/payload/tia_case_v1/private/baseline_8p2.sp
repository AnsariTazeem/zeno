.subckt feedback sense out vref
Rf out sense 10000
Cf out sense 8.1999999999999998e-12
.ends feedback
