.subckt feedback drive load fb
Riso drive load 330
Rlocal drive fb 660
Rsense load fb 1000
Rtrim fb 0 200000
Cguard load 0 3e-10
.ends feedback
