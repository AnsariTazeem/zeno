.subckt feedback drive load fb
Riso drive load 1000
Rfb drive fb 1
.ends feedback
