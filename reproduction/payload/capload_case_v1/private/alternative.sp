.subckt feedback drive load fb
Riso drive load 820
Rfb drive fb 820
Rg fb 0 100000
.ends feedback
