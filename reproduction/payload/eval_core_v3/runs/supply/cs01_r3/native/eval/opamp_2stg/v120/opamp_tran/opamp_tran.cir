* Follower step-response testbench (from tb_Opamp_2stg_tran): VCM +/- Vstep/2 pulse, period T.
* DUT: .subckt dut iref inp inn out.
.lib ../../../../../../../analog_public_v1/deps/pdk/sky130A/libs.tech/combined/sky130.lib.spice tt
.param VDD=1.2 Iref=20u
.global vdd
.options reltol=1e-4 gmin=1e-12 vntol=1e-7 abstol=1e-13
.temp 27

* Compiled component-only pilot DUT; no supplied simulator commands.
.subckt dut iref inp inn out
rb iref nb 27000
xnb nb nb 0 0 sky130_fd_pr__nfet_01v8_lvt W=20 L=2 nf=1 m=1
rbt nb pcb 140000
rbb pcb 0 420000
cbn nb 0 5.0000000000000002e-11
cbnc iref 0 5.0000000000000002e-11
cbpc pcb 0 5.0000000000000002e-11
xnt tail nb 0 0 sky130_fd_pr__nfet_01v8_lvt W=80 L=2 nf=1 m=1
xni1 na inp tail 0 sky130_fd_pr__nfet_01v8_lvt W=75 L=1.5 nf=1 m=1
xni2 nbm inn tail 0 sky130_fd_pr__nfet_01v8_lvt W=75 L=1.5 nf=1 m=1
xnc1 stage iref na 0 sky130_fd_pr__nfet_01v8_lvt W=120 L=0.5 nf=1 m=1
xnc2 mirror iref nbm 0 sky130_fd_pr__nfet_01v8_lvt W=120 L=0.5 nf=1 m=1
xpl1 pa mirror vdd vdd sky130_fd_pr__pfet_01v8_lvt W=140 L=1 nf=1 m=1
xpl2 pb mirror vdd vdd sky130_fd_pr__pfet_01v8_lvt W=140 L=1 nf=1 m=1
xpc1 mirror pcb pa pa sky130_fd_pr__pfet_01v8_lvt W=140 L=1 nf=1 m=1
xpc2 stage pcb pb pb sky130_fd_pr__pfet_01v8_lvt W=140 L=1 nf=1 m=1
xpo out stage vdd vdd sky130_fd_pr__pfet_01v8_lvt W=180 L=0.34999999999999998 nf=1 m=1
xno out nb 0 0 sky130_fd_pr__nfet_01v8_lvt W=125 L=2 nf=1 m=1
rz na comp 500
cc comp out 1.8e-12
.ends dut

VSUP vdd 0 dc {VDD}
.param VCM=0.9 CL=1p Vstep=0.2 T=100n td=5n tr=10p
IREF vdd niref dc {Iref}
VIN nin 0 dc {VCM-Vstep/2} PULSE({VCM-Vstep/2} {VCM+Vstep/2} {td} {tr} {tr} {T/2-tr} {T})
XDUT niref nin nout nout dut
CL nout 0 {CL}

.control
set wr_singlescale
set wr_vecnames
option numdgt=10
tran 5p 200n 0 5p
wrdata tran.txt v(nin) v(nout) i(VSUP)
.endc
.end
