.subckt feedback sense out vref
Rf out sense 10000
Cf out sense 9e-12
Cpad sense vref 3e-11
.ends feedback
