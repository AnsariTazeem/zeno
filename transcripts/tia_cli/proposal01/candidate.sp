.subckt feedback sense out vref
Rf out sense 10000
Cf out sense 5.2e-12
Rd sense damp 680
Cd damp vref 1e-7
.ends feedback
