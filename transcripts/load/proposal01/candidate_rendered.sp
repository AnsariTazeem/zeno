.subckt feedback drive load fb
Riso drive load 330
Rsense load fb 10000
Cfast drive fb 3.3e-11
.ends feedback
