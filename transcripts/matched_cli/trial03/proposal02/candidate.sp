.subckt feedback sense out vref
Rf out sense 10000
Cf out sense 9e-12
Cs sense vref 2.7e-11
.ends feedback
