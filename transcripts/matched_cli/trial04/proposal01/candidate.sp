.subckt feedback drive load fb
Riso drive load 1000
Rtop drive fb 1000
Rbottom fb 0 100000
.ends feedback
